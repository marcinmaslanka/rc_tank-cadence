`include "discipline.h"

module rc_lowpass (
    input  electrical in,      // Input
    output electrical out      // Output
);

    parameter real R = 1k;     // Resistance in Ohms
    parameter real C = 1u;     // Capacitance in Farads

    electrical n1; // Intermediate node: between R and C

    analog begin
        // Resistor between input and intermediate node
        V(in, n1) <+ I(in, n1) * R;

        // Capacitor between intermediate node and ground
        I(n1) <+ C * ddt(V(n1));

        // Output directly connected to the intermediate node
        V(out) <+ V(n1);
    end

endmodule
